V1 1 0 STEP(0 1.2 0)
R1 1 2 10K
C1 2 0 1u

.tran 1u 50m
.print v 2
